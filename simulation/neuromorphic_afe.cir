* Neuromorphic IR Event Sensor - Complete AFE SPICE Netlist
* Channel: Top-Left (TL) Analog Front-End & Asynchronous Event Chain
* Engine: Berkeley SPICE / NGSPICE 46 Compatible
* Reference: docs/DESIGN_SPECIFICATION.md

.title Neuromorphic IR Event Sensor Single-Channel AFE SPICE Simulation

* ==============================================================================
* Power Supplies and Reference Voltages
* ==============================================================================
VCC 3V3 0 DC 3.3
VREF_SRC VREF_RAW 0 DC 1.25

* Low-pass decoupled VREF buffer (REF3312 model)
R_REF_OUT VREF_RAW VREF 1.0
C_REF_DEC1 VREF 0 1u
C_REF_DEC2 VREF 0 100n

* ==============================================================================
* Threshold Voltage Generation (Precision E96 Dividers)
* VTH_ON = 1.25V + (3.3V - 1.25V)*(10k / (499k + 10k)) = 1.25V + 0.0402V = 1.2902V
* VTH_OFF = 1.25V * (301k / (301k + 10k)) = 1.25V - 0.0402V = 1.2098V
* ==============================================================================
R_ON_HI 3V3 VTH_ON 499k
R_ON_LO VTH_ON VREF 10.0k
C_ON_DEC VTH_ON 0 10n

R_OFF_HI VREF VTH_OFF 10.0k
R_OFF_LO VTH_OFF 0 301k
C_OFF_DEC VTH_OFF 0 10n

* ==============================================================================
* Photodiode Model (Vishay BPW34S / VBPW34FASR)
* Modeled as dynamic photocurrent source in parallel with junction capacitance Cd
* Cd ~ 65 pF at Vr = 1.25V, Rshunt = 10G
* Direction: Anode at IN_TIA, Cathode at VREF (increasing light pulls current from VPHOTO)
* ==============================================================================
* Stimulus Sequence:
* 0 - 5ms:   Steady ambient baseline = 10 uA
* 5 - 5.02ms: Target enter step to 40 uA (delta = +30 uA, 20us rise) -> ON event
* 5.02 - 20ms: Steady target plateau = 40 uA (adaptation decay)
* 20 - 20.02ms: Target exit step down to 10 uA (delta = -30 uA, 20us fall) -> OFF event
* 20.02 - 35ms: Steady baseline = 10 uA
* 35 - 50ms: Slow ambient lighting ramp from 10 uA to 50 uA (drift immunity test)
* 50 - 60ms: Return to 10 uA
* ==============================================================================
I_PHOTO IN_TIA VREF PWL(
+ 0ms 10u
+ 5ms 10u
+ 5.02ms 40u
+ 20ms 40u
+ 20.02ms 10u
+ 35ms 10u
+ 50ms 50u
+ 51ms 10u
+ 60ms 10u
+ )

C_PD IN_TIA VREF 65p
R_SH_PD IN_TIA VREF 10G

* ==============================================================================
* Transimpedance Amplifier (TIA) - Texas Instruments OPA381 Macromodel
* Non-inverting input = VREF (1.25V), Inverting input = IN_TIA
* Output = VPHOTO
* RF = 18.0k (0.1%), CF = 47pF (C0G/NP0)
* ==============================================================================
R_F IN_TIA VPHOTO 18.0k
C_F IN_TIA VPHOTO 47p

* Texas Instruments Official OPA381 Macromodel (OPAx381.LIB from TI)
X_OPA381 VREF IN_TIA 3V3 0 VPHOTO OPAx381

* ==============================================================================
* Temporal Adaptation / AC Differentiation Stage
* C_A = 100nF, R_A = 22.0k tied to VREF (tau = 2.20ms, fc = 72.3Hz)
* Output node = VEVENT
* ==============================================================================
C_A VPHOTO VEVENT 100n
R_A VEVENT VREF 22.0k

* Parasitic loading / probe capacitance
C_LOAD VEVENT 0 5p

* ==============================================================================
* Dual Event Comparators - Texas Instruments TLV3202 Macromodel
* Comparator A: ON Event (VEVENT > VTH_ON -> RAW_ON high)
* Comparator B: OFF Event (VEVENT < VTH_OFF -> RAW_OFF high)
* ==============================================================================
* ON Comparator: Non-inv = VEVENT, Inv = VTH_ON
X_COMP_ON VEVENT VTH_ON 3V3 0 RAW_ON TLV3202_BEHAVIORAL

* OFF Comparator: Non-inv = VTH_OFF, Inv = VEVENT
X_COMP_OFF VTH_OFF VEVENT 3V3 0 RAW_OFF TLV3202_BEHAVIORAL

* ==============================================================================
* Monostable Multivibrator Pulse Shapers - 74LVC1G123
* Input: RAW_ON, RAW_OFF (positive edge triggered)
* Output: SPIKE_ON, SPIKE_OFF (calibrated ~100 us digital pulses)
* Timing: R_EXT = 8.2k, C_EXT = 12nF
* ==============================================================================
X_OS_ON RAW_ON 3V3 0 SPIKE_ON MONOSTABLE_100US
X_OS_OFF RAW_OFF 3V3 0 SPIKE_OFF MONOSTABLE_100US

* Output termination
R_TERM_ON SPIKE_ON 0 100k
R_TERM_OFF SPIKE_OFF 0 100k

* Initial condition for monostable timing caps
.ic v(x_os_on.n_time)=3.3 v(x_os_off.n_time)=3.3

* ==============================================================================
* Behavioral Subcircuit Definitions
* ==============================================================================

* Texas Instruments Official Production SPICE Model (Rev B, 2022)
* Downloaded directly from Texas Instruments (sboc073)
* Pinout Order: +IN -IN +V -V OUT (pins 3 2 1 4 6)
.include "simulation/ti_models/opa381/OPAx381.LIB"

* TLV3202 Dual High-Speed Rail-to-Rail Comparator (tpd = 25ns, 4mV hysteresis)
.SUBCKT TLV3202_BEHAVIORAL IN_P IN_N VDD VSS OUT
* Input differential voltage with 4mV built-in hysteresis
B_SW N_INT 0 V = (v(IN_P) - v(IN_N) + (v(OUT) > 1.65 ? 0.002 : -0.002)) > 0 ? 3.3 : 0.0
* 25ns propagation delay RC network
R_DELAY N_INT N_DEL 1k
C_DELAY N_DEL 0 25p
* Output buffer
B_BUF OUT 0 V = v(N_DEL) > 1.65 ? 3.3 : 0.0
.ENDS TLV3202_BEHAVIORAL

* SPICE Switch Model for Monostable Reset
.MODEL sw_mod SW(RON=1 ROFF=100MEG VT=1.0 VH=0.1)

* 74LVC1G123 Monostable Multivibrator Pulse Shaper (~100 us pulse)
.SUBCKT MONOSTABLE_100US TRIG VDD VSS SPIKE
* Trigger differentiator to extract positive edge
C_TRIG TRIG N_PULSE 47p
R_TRIG N_PULSE VSS 10k
* External timing network (Rext = 8.2k, Cext = 12nF -> tau = 98.4 us)
R_EXT VDD N_TIME 8.2k
C_EXT N_TIME VSS 12n
* Pull-down switch: discharges timing cap on rising edge of trigger
S_TRIG N_TIME VSS N_PULSE VSS sw_mod
* Output comparator: asserts high while timing cap charges toward 63.2% VDD (2.08V)
B_OUT SPIKE VSS V = (v(N_TIME) < 2.08) ? 3.3 : 0.0
.ENDS MONOSTABLE_100US

* ==============================================================================
* Simulation Analysis Commands
* ==============================================================================
.tran 5u 60m 0 5u

.options plotwinsize=0
.options numdgt=7

.probe V(IN_TIA) V(VPHOTO) V(VEVENT) V(VTH_ON) V(VTH_OFF) V(RAW_ON) V(RAW_OFF) V(SPIKE_ON) V(SPIKE_OFF) I(I_PHOTO)

.end
